* CE voltage-divider amplifier - generated by spice_engine.py
.model 2N3904 NPN(Is=6.734f Xti=3 Eg=1.11 Vaf=74.03 Bf=416.4 Ne=1.259 Ise=6.734f Ikf=66.78m Xtb=1.5 Br=.7371 Nc=2 Isc=0 Ikr=0 Rc=1 Cjc=3.638p Mjc=.3085 Vjc=.75 Fc=.5 Cje=4.493p Mje=.2593 Vje=.75 Tr=239.5n Tf=301.2p Itf=.4 Vtf=4 Xtf=2 Rb=10)
VCC vcc 0 DC 12
VIN in 0 DC 0 AC 1 SIN(0 0.01 1000)
R1 vcc b 100000
R2 b 0 22000
RC vcc c 2200
RE e 0 1000
Q1 c b e 2N3904
CIN in b 1e-05
COUT c out 1e-05
RL out 0 10000
.save all @q1[ic] @q1[ib]
.option filetype=ascii
.op
.ac dec 20 10 1e+07
.tran 5e-06 5e-03
.end
